ADE simulation setup
Test mem_lib_m_t_test_1: mem_lib/m_t_test/schematic, simulator spectre
  Models: /home/install/FOUNDRY/analog/45nm/gpdk045/../models/spectre/gpdk045.scs[mc]
  Temperature: 27
  Analysis tran: stop=10u
  Signals: /net1, /net2, /net4, /net3
Run mode: Single Run, Sweeps and Corners
