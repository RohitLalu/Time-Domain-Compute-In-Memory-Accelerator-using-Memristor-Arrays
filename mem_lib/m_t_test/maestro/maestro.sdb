ADE simulation setup
Run mode: Single Run, Sweeps and Corners
Tests:
  mem_lib_m_t_test_1: mem_lib/m_t_test/schematic, simulator spectre
