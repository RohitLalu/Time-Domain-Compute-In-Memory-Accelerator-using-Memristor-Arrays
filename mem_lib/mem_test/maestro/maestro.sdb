ADE simulation setup
Run mode: Single Run, Sweeps and Corners
Tests:
  mem_lib_mem_test_1: mem_lib/mem_test/schematic, simulator spectre
