ADE simulation setup
Test mem_lib_mem_test_1: mem_lib/mem_test/schematic, simulator spectre
  Models: /home/install/FOUNDRY/analog/45nm/gpdk045/../models/spectre/gpdk045.scs[mc]
  Temperature: 27
  Analysis tran: stop=4u
  Signals: /I2/TE (terminal), /net1
Run mode: Single Run, Sweeps and Corners
