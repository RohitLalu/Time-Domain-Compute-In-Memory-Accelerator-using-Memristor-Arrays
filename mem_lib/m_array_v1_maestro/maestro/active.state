ADE simulation setup
Test mem_lib_m_array_v1_1: mem_lib/m_array_v1/schematic, simulator spectre
  Models: /home/install/FOUNDRY/analog/45nm/gpdk045/../models/spectre/gpdk045.scs[mc]
  Temperature: 27
  Analysis tran: stop=100n
  Signals: /input_val, /weight_ctrl, /input_ctrl, /WL_ctrl, /pre_ch_Ctrl, /cap_op, /latch_out, /I0/sl (terminal), /I8/cap_vdd (terminal), /check_vds, /I0/bl (terminal), /V10/MINUS (terminal), /V10/PLUS (terminal)
Run mode: Single Run, Sweeps and Corners
