ADE simulation setup
Test mem_lib_m_array_v1_1: mem_lib/m_array_v1/schematic, simulator spectre
  Models: /home/install/FOUNDRY/analog/45nm/gpdk045/../models/spectre/gpdk045.scs[mc]
  Temperature: 27
  Files: definitions /home/rohit/project/mem_lib/mysave.scs
  Analysis tran: stop=400n
  Signals: /WL_ctrl, /input_, /pre_ch_Ctrl, /cap_op, /latch_out, /gap_d, /weight_ctrl_bar
Run mode: Single Run, Sweeps and Corners
