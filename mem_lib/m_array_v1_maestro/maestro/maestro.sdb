ADE simulation setup
Run mode: Single Run, Sweeps and Corners
Tests:
  mem_lib_m_array_v1_1: mem_lib/m_array_v1/schematic, simulator spectre
