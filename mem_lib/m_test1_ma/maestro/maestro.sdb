ADE simulation setup
Run mode: Single Run, Sweeps and Corners
Tests:
  mem_lib_m_test1_1: mem_lib/m_test1/schematic, simulator spectre
