ADE simulation setup
Test mem_lib_m_test1_1: mem_lib/m_test1/schematic, simulator spectre
  Models: /home/install/FOUNDRY/analog/45nm/gpdk045/../models/spectre/gpdk045.scs[mc]
  Temperature: 27
  Analysis tran: stop=1u
  Signals: /V0/MINUS (terminal), /V0/PLUS (terminal), /gap_d, /net2
Run mode: Single Run, Sweeps and Corners
