ADE simulation setup
Run mode: Single Run, Sweeps and Corners
Tests:
  mem_lib_m_test2_1: mem_lib/m_test2/schematic, simulator spectre
