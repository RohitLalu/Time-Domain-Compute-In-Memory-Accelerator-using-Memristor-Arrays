ADE simulation setup
Test mem_lib_m_test2_1: mem_lib/m_test2/schematic, simulator spectre
  Models: /home/install/FOUNDRY/analog/45nm/gpdk045/../models/spectre/gpdk045.scs[mc]
  Temperature: 27
  Analysis tran: stop=10u
  Signals: /I0/TE (terminal), /net3, /gap_d, /net2, /net6, /net1
Run mode: Single Run, Sweeps and Corners
