//
`include "constants.vams"
`include "disciplines.vams"

module rram_v_1_0_0(TE, BE);
    // electrical properties, top electrode TE, bottom electrode BE
    inout       TE, BE;
    electrical  TE, BE;

    // Version Parameter
    parameter real    version      = 1.00 from(0:inf);

    // Switch to select Standard Model (0) or Dynamic Model (1)
    // FIX: Changed comma to colon in range
    parameter integer model_switch = 1    from[0:1];

    // The following constants have been pre-defined in the constants.vams
    parameter real    kb      = `P_K;
    parameter real    q       = `P_Q;

    // average switching fitting parameters g0, V0, I0, beta, gamma0
    parameter real    g0      = 0.25e-9 from(0:2e-9);
    parameter real    V0      = 0.25    from(0:10);
    parameter real    Vel0    = 10      from(0:20);
    parameter real    I0      = 1000e-6 from(0:1e-2);
    parameter real    beta    = 0.8     from(0:inf);
    parameter real    gamma0  = 16      from(0:inf);

    // threshold temperature for significant random variations
    // FIX: Changed comma to colon
    parameter real    T_crit  = 450     from(390:460);

    // variations fitting parameters
    // FIX: Changed comma to colon
    parameter real    deltaGap0 = 0.02  from[0:0.1);

    // FIX: Changed comma to colon
    parameter real    T_smth    = 500   from(400:600);

    // activation energy for vacancy generation
    parameter real    Ea      = 0.6 from(0:1);

    // atom spacing, a0
    parameter real    a0      = 0.25e-9 from(0:inf);

    // initial room temperature in devices
    parameter real    T_ini   = 273 + 25 from(0:inf);

    // minimum field requirement to enhance gap formation, F_min
    parameter real    F_min   = 1.4e9 from(0:3e9);

    // initial gap distance, gap_ini
    parameter real    gap_ini = 5e-9 from(0:100e-10);

    // minimum gap distance, gap_min
    parameter real    gap_min = 2e-10 from(0:100e-10);

    // maximum gap distance, gap_max
    parameter real    gap_max = 17e-10 from(0:100e-10);

    // thermal resistance
    parameter real    Rth     = 2.1e3 from(0:inf);

    // oxide thickness, thickness
    parameter real    tox     = 12e-9 from(0:100e-9);

    // initial random seed
    parameter integer rand_seed_ini = 0 from(-1.6e9:1.6e9);

    // time step boundary
    // FIX: Changed comma to colon
    parameter real    time_step = 1e-9 from(1e-15:1);

    // voltage V(TE, BE), Vtb; current I(TE, BE), Itb
    real    Vtb, Itb;

    // present temperature in devices, temp
    real    T_cur;

    // gap time derivative, gap_ddt; random gap time derivative, gap_random_ddt
    real    gap_ddt, gap_random_ddt;

    // present gap status
    real    gap;

    // local enhancement factor, gamma
    real    gamma;
    real    gamma_ini;

    // random number
    integer rand_seed;
    real    deltaGap;

    // FIX: Changed '20n' to '20e-9' for standard compliance
    parameter real pulse_width = 20e-9;

   analog begin
        $bound_step(time_step);

        Vtb = V(TE,BE);

        // STABILITY FIX 1: Calculate Itb first using the state from the PREVIOUS step
        // This breaks the algebraic loop for T_cur
        Itb = I0 * limexp(-gap/g0) * sinh(Vtb/V0);

        // STABILITY FIX 2: Prevent T_cur from being zero or negative
        T_cur = T_ini + abs(Vtb * Itb * Rth);
        if (T_cur < 200) T_cur = 200;

        gamma_ini = (Vtb < 0) ? 16 : gamma0;

        // Use a temp variable for gap to prevent "chatter"
        gamma = gamma_ini - beta * pow((gap/1e-9), 3);

        // STABILITY FIX 3: Smooth the Gamma transition
        if ((gamma * abs(Vtb) / tox) < F_min) begin
            gamma = 0;
        end

        // Use limexp to prevent numerical explosion
        gap_ddt = - Vel0 * limexp(-q * Ea / (kb * T_cur)) * sinh(gamma * a0 / tox * q * Vtb / (kb * T_cur));

        deltaGap = deltaGap0 * model_switch;
        gap_random_ddt = $rdist_normal(rand_seed, 0, 1) * deltaGap / (1 + limexp((T_crit - T_cur)/T_smth));

        // State integration
        gap = idt(gap_ddt + gap_random_ddt, gap_ini);

        // STABILITY FIX 4: Use soft-clamping for the integrator limits if possible,
        // or ensure the Itb calculation uses the clamped gap.
        if(gap < gap_min) gap = gap_min;
        if(gap > gap_max) gap = gap_max;

        // Final Contribution
        I(TE,BE) <+ I0 * limexp(-gap/g0) * sinh(Vtb/V0);
    end
endmodule
